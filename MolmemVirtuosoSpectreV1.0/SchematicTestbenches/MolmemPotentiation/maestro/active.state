ADE simulation setup
Test SchematicTestbenches_MolmemPotentiation_1: SchematicTestbenches/MolmemPotentiation/schematic, simulator spectre
  Models: /home/cadence0/Desktop/MolmemVirtuosoSpectreV1.0/molmem.scs
  Temperature: 27
  Analysis tran: stop=2.7m
  Signals: /net2, /I0/Anode (terminal)
Run mode: Single Run, Sweeps and Corners
