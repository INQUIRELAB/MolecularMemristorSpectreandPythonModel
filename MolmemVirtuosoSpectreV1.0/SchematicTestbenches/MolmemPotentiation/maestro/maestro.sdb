ADE simulation setup
Run mode: Single Run, Sweeps and Corners
Tests:
  SchematicTestbenches_MolmemPotentiation_1: SchematicTestbenches/MolmemPotentiation/schematic, simulator spectre
