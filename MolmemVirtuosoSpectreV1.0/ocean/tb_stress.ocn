; ============================================================================
; Cadence Virtuoso Viva Waveform Display Script: tb_stress.ocn
; File: MolmemVirtuosoSpectreV1.0/ocean/tb_stress.ocn
; ============================================================================

simulator('spectre)

resultsDir = cond(
    (isDir("./tb_stress.raw")               "./tb_stress.raw")
    (isDir("./testbenches/tb_stress.raw")   "./testbenches/tb_stress.raw")
    (isDir("../testbenches/tb_stress.raw")  "../testbenches/tb_stress.raw")
    (t                                      "./tb_stress.raw")
)
if(isDir(resultsDir) then
    openResults(resultsDir)

    availResults = results()
    cond(
        (member('tran availResults)              selectResult('tran))
        (member("tran-tran" availResults)        selectResult("tran-tran"))
        (member('tranStress availResults)        selectResult('tranStress))
        (member('tranStress-tran availResults)   selectResult('tranStress-tran))
        (member("tranStress-tran" availResults)  selectResult("tranStress-tran"))
        (member('tran-tran availResults)         selectResult('tran-tran))
        (t
            ; Fallback: prefer transient dataset over static variables table
            let((tranDs)
                tranDs = car(setof(x availResults pcreMatchp("tran" sprintf(nil "%s" x))))
                if(tranDs then
                    selectResult(tranDs)
                else
                    if(availResults then selectResult(car(last(availResults))))
                )
            )
        )
    )

    win = newWindow()
    when(isCallable('addSubwindowTitle)
        addSubwindowTitle("MolMemristor Stress Test (Cadence Spectre)")
    )
    when(isCallable('awvSetWindowTitle) && boundp('win) && win
        awvSetWindowTitle(win "MolMemristor Stress Test (Cadence Spectre)")
    )

    vStress      = nil
    errset(vStress = v("driveNode") || v("vStress") || v("V_stress") || v("/driveNode") nil)
    pulseState   = nil
    errset(pulseState = v("pulseState") || v("n_mon") || v("/pulseState") nil)
    f22          = nil
    errset(f22 = v("f22") || v("condState") || v("f22_mon") || v("/f22") nil)
    conductance  = nil
    errset(conductance = v("conductance") || v("g_mon") || v("/conductance") nil)
    iMem         = nil
    errset(iMem = i("Xdut:Anode") * 1.0e3 || i("/Xdut/Anode") * 1.0e3 nil)
    junctionTemp = nil
    errset(junctionTemp = v("junctionTemp") || v("temp_mon") || v("/junctionTemp") nil)

    when(vStress      plot(vStress      ?expr '("Stress Voltage (V)")))
    when(pulseState   when(isCallable('addStrip) addStrip()) plot(pulseState   ?expr '("Internal Pulse State (n)")))
    when(f22          when(isCallable('addStrip) addStrip()) plot(f22          ?expr '("Conductance State (f22)")))
    when(conductance  when(isCallable('addStrip) addStrip()) plot(conductance  ?expr '("Read Conductance (mS)")))
    when(iMem         when(isCallable('addStrip) addStrip()) plot(iMem         ?expr '("Current (mA)")))
    when(junctionTemp when(isCallable('addStrip) addStrip()) plot(junctionTemp ?expr '("Junction Temperature (K)")))

    printf("[Ocean] Waveforms successfully plotted to Viva window.\n")
else
    printf("[Ocean] Error: Results directory '%s' not found. Run 'spectre tb_stress.scs' first.\n" resultsDir)
)
